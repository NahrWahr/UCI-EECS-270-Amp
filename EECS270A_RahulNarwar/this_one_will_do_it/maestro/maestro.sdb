ADE simulation setup
Run mode: Single Run, Sweeps and Corners
Tests:
  EECS270A_RahulNarwar_this_one_will_do_it_1: EECS270A_RahulNarwar/this_one_will_do_it/schematic, simulator spectre
    Variables: alpha_n02 = 1; alpha_n03 = 1; alpha_n11 = 1; alpha_p02 = 1; alpha_p03 = 1; alpha_p11 = 1; alpha_p12 = 1; Vcm = 3.45; VDD = 4; Wn = 45u; Wp = 45u
